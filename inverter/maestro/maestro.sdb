ADE simulation setup
Run mode: Single Run, Sweeps and Corners
Tests:
  TIA_ring_OSC_1: TIA/inverter/schematic, simulator spectre
    Variables: vin = {From/To}Linear:0.1:0.01:1.8{From/To}
