ADE simulation setup
Test TIA_ring_OSC_1: TIA/inverter/schematic, simulator spectre
  Models: /home/aa/users/cs199-cdt/cadence/sky130_release_0.0.4/libs/sky130_fd_pr_main/../../models/sky130.lib.spice[tt]
  Variables: vin = {From/To}Linear:0.1:0.01:1.8{From/To}
  Temperature: 27
  Analysis dc: (saves the operating point)
  Output VDC("/vout")
  Signals: /vout
Run mode: Single Run, Sweeps and Corners
