ADE simulation setup
Test TIA_MEMS_1: TIA/MEMS/schematic, simulator spectre
  Models: /home/aa/users/cs199-cdt/cadence/sky130_release_0.0.4/libs/sky130_fd_pr_main/../../models/sky130.lib.spice[tt]
  Temperature: 27
  Analysis ac: start=100M stop=150M step=1M
  Output test = (Y_dB = (20 * log10((1 / abs((V Vin Vout)))))) (unticked)
  Signals: /Vout
Run mode: Single Run, Sweeps and Corners
