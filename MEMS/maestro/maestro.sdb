ADE simulation setup
Run mode: Single Run, Sweeps and Corners
Tests:
  TIA_MEMS_1: TIA/MEMS/schematic, simulator spectre
    Outputs: test
