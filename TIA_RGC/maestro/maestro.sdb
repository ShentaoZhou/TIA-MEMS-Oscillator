ADE simulation setup
Run mode: Single Run, Sweeps and Corners
Tests:
  TIA_TIA_RGC_1: TIA/TIA_RGC/schematic, simulator spectre
