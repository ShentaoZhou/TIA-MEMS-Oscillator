ADE simulation setup
Test TIA_TIA_RGC_1: TIA/TIA_RGC/schematic, simulator spectre
  Models: /home/aa/users/cs199-cdt/cadence/sky130_release_0.0.4/models/sky130.lib.spice[tt]
  Temperature: 27
  Analysis dc: (saves the operating point)
  Analysis ac: start=0 stop=500M step=10M
  Output IF("/I8/MINUS") (unticked)
  Output (VF("/Vout") / IF("/I8/MINUS")) (unticked)
  Signals: /Vout, /I8/MINUS (terminal)
Run mode: Single Run, Sweeps and Corners
