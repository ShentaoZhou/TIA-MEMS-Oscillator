ADE simulation setup
Run mode: Single Run, Sweeps and Corners
Tests:
  TIA_Ideal_1: TIA/Ideal/schematic, simulator spectre
    Variables: I = 10m; num = 1
