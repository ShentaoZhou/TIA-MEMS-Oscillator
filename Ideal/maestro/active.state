ADE simulation setup
Test TIA_Ideal_1: TIA/Ideal/schematic, simulator spectre
  Models: /home/aa/users/cs199-cdt/cadence/sky130_release_0.0.4/libs/sky130_fd_pr_main/../../models/sky130.lib.spice[tt]
  Variables: I = 10m; num = 1
  Temperature: 27
  Analysis stb: start=1M stop=1G dec=1000 probe=/IPRB0 stbProbeMode=single-ended
  Analysis dc: (saves the operating point)
  Output VF("/Vout2") (unticked)
  Output VT("/Vout2") (unticked)
  Output IT("/V0/PLUS") (unticked)
  Output IF("/V0/PLUS") (unticked)
  Output (VF("/Vout2") / IF("/V0/PLUS")) (unticked)
  Output (VF("/Vout2") / IF("/I17/Iout")) (unticked)
  Output Loop Gain Phase = phaseDegUnwrapped(getData("loopGain" ?result "stb"))
  Output Loop Gain dB20 = db(mag(getData("loopGain" ?result "stb")))
  Signals: /Vout2, /V0/PLUS (terminal), /I17/Iout (terminal)
Run mode: Single Run, Sweeps and Corners
